* 6T SRAM butterfly curves (two half-cells, loop broken)
.include ../models/45nm_LP.pm
.param supply=1.1 Lch=45n Wpd=180n Wax=90n Wpu=90n wlv=0
Vdd vdd 0 {supply}
Vwl wl 0 {wlv}
* one swept source drives the input of both half-cells
Vs in 0 0

* half-cell A: input Q (swept), output QB
Mpd_a outa in 0 0 nmos W={Wpd} L={Lch}
Mpu_a outa in vdd vdd pmos W={Wpu} L={Lch}
Max_a vdd wl outa 0 nmos W={Wax} L={Lch}

* half-cell B: input QB (swept), output Q
Mpd_b outb in 0 0 nmos W={Wpd} L={Lch}
Mpu_b outb in vdd vdd pmos W={Wpu} L={Lch}
Max_b vdd wl outb 0 nmos W={Wax} L={Lch}

.step param wlv list 0 1.1
.dc Vs 0 {supply} 0.005
.end
